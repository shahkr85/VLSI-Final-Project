ADE simulation setup
Run mode: Single Run, Sweeps and Corners
Tests:
  Project:V_INV:1: Project/V_INV/schematic, simulator spectre
Global variables:
  vin = 1.5
  wn = 3u
  wp = 3u
