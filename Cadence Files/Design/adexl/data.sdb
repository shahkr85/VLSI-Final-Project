ADE simulation setup
Run mode: Single Run, Sweeps and Corners
Tests:
  Project:Design:1: Project/Design/schematic, simulator spectre
Global variables:
  PRESET = 1
  CLEAR = 1
