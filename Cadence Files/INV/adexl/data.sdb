ADE simulation setup
Run mode: Single Run, Sweeps and Corners
Tests:
  Lab3:invx:1: Lab3/invx/schematic, simulator spectre
Global variables:
  vin = 1.5
  wn = 3u
  wp = 3u
