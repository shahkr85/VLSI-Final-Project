ADE simulation setup
Run mode: Single Run, Sweeps and Corners
Tests:
  Project:schemSim_X3NAND:1: Project/schemSim_X3NAND/schematic, simulator spectre
