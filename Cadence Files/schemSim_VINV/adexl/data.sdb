ADE simulation setup
Run mode: Single Run, Sweeps and Corners
Tests:
  Project:schemSim_VINV:1: Project/schemSim_VINV/schematic, simulator spectre
