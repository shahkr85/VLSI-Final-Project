ADE simulation setup
Run mode: Single Run, Sweeps and Corners
Tests:
  Project:sim_X3NAND:1: Project/sim_X3NAND/config, simulator spectre
