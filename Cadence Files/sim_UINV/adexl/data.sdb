ADE simulation setup
Run mode: Single Run, Sweeps and Corners
Tests:
  Project:sim_UINV:1: Project/sim_UINV/config, simulator spectre
