ADE simulation setup
Run mode: Single Run, Sweeps and Corners
Tests:
  Project:sim_Z2NAND:1: Project/sim_Z2NAND/config, simulator spectre
