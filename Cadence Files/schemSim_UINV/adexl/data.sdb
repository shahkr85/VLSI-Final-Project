ADE simulation setup
Run mode: Single Run, Sweeps and Corners
Tests:
  Project:schemSim_UINV:1: Project/schemSim_UINV/schematic, simulator spectre
