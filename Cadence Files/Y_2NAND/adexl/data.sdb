ADE simulation setup
Run mode: Single Run, Sweeps and Corners
Tests:
  Project:Y_2NAND:1: Project/Y_2NAND/schematic, simulator spectre
