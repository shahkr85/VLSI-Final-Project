ADE simulation setup
Run mode: Single Run, Sweeps and Corners
Tests:
  Project:W_2NAND:1: Project/W_2NAND/schematic, simulator spectre
