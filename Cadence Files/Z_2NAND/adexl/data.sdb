ADE simulation setup
Run mode: Single Run, Sweeps and Corners
Tests:
  Project:Z_2NAND:1: Project/Z_2NAND/schematic, simulator spectre
Global variables:
  A = 1
  B = 0
