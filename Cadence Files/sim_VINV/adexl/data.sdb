ADE simulation setup
Run mode: Single Run, Sweeps and Corners
Tests:
  Project:sim_VINV:1: Project/sim_VINV/config, simulator spectre
