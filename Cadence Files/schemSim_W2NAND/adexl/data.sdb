ADE simulation setup
Run mode: Single Run, Sweeps and Corners
Tests:
  Project:schemSim_W2NAND:1: Project/schemSim_W2NAND/schematic, simulator spectre
