ADE simulation setup
Run mode: Single Run, Sweeps and Corners
Tests:
  Project:schemSim_Y2NAND:1: Project/schemSim_Y2NAND/schematic, simulator spectre
