ADE simulation setup
Run mode: Single Run, Sweeps and Corners
Tests:
  Project:FlipFlopTest:1: Project/FlipFlopTest/schematic, simulator spectre
