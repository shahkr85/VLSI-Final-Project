ADE simulation setup
Run mode: Single Run, Sweeps and Corners
Tests:
  Project:sim_W2NAND:1: Project/sim_W2NAND/config, simulator spectre
