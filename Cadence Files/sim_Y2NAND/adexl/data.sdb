ADE simulation setup
Run mode: Single Run, Sweeps and Corners
Tests:
  Project:sim_Y2NAND:1: Project/sim_Y2NAND/config, simulator spectre
