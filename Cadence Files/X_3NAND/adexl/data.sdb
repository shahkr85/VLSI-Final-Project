ADE simulation setup
Run mode: Single Run, Sweeps and Corners
Tests:
  Project:X_3NAND:1: Project/X_3NAND/schematic, simulator spectre
