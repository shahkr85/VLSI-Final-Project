ADE simulation setup
Run mode: Single Run, Sweeps and Corners
Tests:
  Project:schemSim_Z2NAND:1: Project/schemSim_Z2NAND/schematic, simulator spectre
