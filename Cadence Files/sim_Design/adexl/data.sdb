ADE simulation setup
Run mode: Single Run, Sweeps and Corners
Tests:
  Project:sim_Design:1: Project/sim_Design/config, simulator spectre
